/* QPZD Model Version 1.1

Project Directors and Developers: Yuehang Xu, Shuman Mao, Xiang Su and Lei Huang, University of Electronic Science and Technology of China

QPZD model is supported by the memebrs of University of Electronic Science and Technology of China.

*/
`include "discipline.h"
`include "constants.h"

////////// Numerical and Physical Constants //////////
`define DOS 3.240e17           //Density of states, Reference M. Shur Plenum Press 1987, GaAs Device and Circuits
`define ep_psi 0.3             //Smoothing Constant
`define Oneby3 0.33333333333333333
`define Oneby6 0.16666666666666667
`define Oneby12 0.0833333333333333
`define Oneby30 0.03333333333333333
`define Twoby3 0.66666666666666667
`define EXPL_THRESHOLD 80.0
`define MAX_EXPL 5.540622384e+34
`define MIN_EXPL 1.804851387e-35
`define KboQ 8.617087e-5       // J/deg
`define k 1.38e-23
`define h 6.626e-34
`define mn 9.11e-31           // Mass of electron
`define deltan 3.23e-20
`define Ct 1e-12
`define Eact 0.52             // Trap activation energy

////////// Macros for the model/instance parameters //////////
/*
 MPRxx    model    parameter real
 MPIxx    model    parameter integer
 IPRxx    instance parameter real
 IPIxx    instance parameter integer
    ||
    cc    closed lower bound, closed upper bound
    oo    open   lower bound, open   upper bound
    co    closed lower bound, open   upper bound
    oc    open   lower bound, closed upper bound
    cz    closed lower bound=0, open upper bound=inf
    oz    open   lower bound=0, open upper bound=inf
    nb    no bounds
    ex    no bounds with exclude
    sw    switch(integer only, values  0=false  and  1=true)
    ty    switch(integer only, values -1=p-type and +1=n-type)

 IPM   instance parameter mFactor(multiplicity, implicit for LRM2.2)
 OPP   operating point parameter, includes units and description for printing
 */

`define OPP(nam,uni,des)               (*units=uni,                   desc=des*)           real    nam ;
`define MPRnb(nam,def,uni,        des) (*units=uni,                   desc=des*) parameter real    nam=def ;
`define MPRex(nam,def,uni,exc,    des) (*units=uni,                   desc=des*) parameter real    nam=def exclude exc ;
`define MPRcc(nam,def,uni,lwr,upr,des) (*units=uni,                   desc=des*) parameter real    nam=def from[lwr:upr] ;
`define MPRoo(nam,def,uni,lwr,upr,des) (*units=uni,                   desc=des*) parameter real    nam=def from(lwr:upr) ;
`define MPRco(nam,def,uni,lwr,upr,des) (*units=uni,                   desc=des*) parameter real    nam=def from[lwr:upr) ;
`define MPRoc(nam,def,uni,lwr,upr,des) (*units=uni,                   desc=des*) parameter real    nam=def from(lwr:upr] ;
`define MPRcz(nam,def,uni,        des) (*units=uni,                   desc=des*) parameter real    nam=def from[  0:inf);
`define MPRoz(nam,def,uni,        des) (*units=uni,                   desc=des*) parameter real    nam=def from(  0:inf);
`define MPInb(nam,def,uni,        des) (*units=uni,                   desc=des*) parameter integer nam=def ;
`define MPIex(nam,def,uni,exc,    des) (*units=uni,                   desc=des*) parameter integer nam=def exclude exc ;
`define MPIcc(nam,def,uni,lwr,upr,des) (*units=uni,                   desc=des*) parameter integer nam=def from[lwr:upr] ;
`define MPIoo(nam,def,uni,lwr,upr,des) (*units=uni,                   desc=des*) parameter integer nam=def from(lwr:upr) ;
`define MPIco(nam,def,uni,lwr,upr,des) (*units=uni,                   desc=des*) parameter integer nam=def from[lwr:upr) ;
`define MPIoc(nam,def,uni,lwr,upr,des) (*units=uni,                   desc=des*) parameter integer nam=def from(lwr:upr] ;
`define MPIcz(nam,def,uni,        des) (*units=uni,                   desc=des*) parameter integer nam=def from[  0:inf);
`define MPIoz(nam,def,uni,        des) (*units=uni,                   desc=des*) parameter integer nam=def from(  0:inf);
`define MPIsw(nam,def,uni,        des) (*units=uni,                   desc=des*) parameter integer nam=def from[  0:  1] ;
`define MPIty(nam,def,uni,        des) (*units=uni,                   desc=des*) parameter integer nam=def from[ -1:  1] exclude 0 ;
`define IPRnb(nam,def,uni,        des) (*units=uni, type="instance",  desc=des*) parameter real    nam=def ;
`define IPRex(nam,def,uni,exc,    des) (*units=uni, type="instance",  desc=des*) parameter real    nam=def exclude exc ;
`define IPRcc(nam,def,uni,lwr,upr,des) (*units=uni, type="instance",  desc=des*) parameter real    nam=def from[lwr:upr] ;
`define IPRoo(nam,def,uni,lwr,upr,des) (*units=uni, type="instance",  desc=des*) parameter real    nam=def from(lwr:upr) ;
`define IPRco(nam,def,uni,lwr,upr,des) (*units=uni, type="instance",  desc=des*) parameter real    nam=def from[lwr:upr) ;
`define IPRoc(nam,def,uni,lwr,upr,des) (*units=uni, type="instance",  desc=des*) parameter real    nam=def from(lwr:upr] ;
`define IPRcz(nam,def,uni,        des) (*units=uni, type="instance",  desc=des*) parameter real    nam=def from[  0:inf);
`define IPRoz(nam,def,uni,        des) (*units=uni, type="instance",  desc=des*) parameter real    nam=def from(  0:inf);
`define IPInb(nam,def,uni,        des) (*units=uni, type="instance",  desc=des*) parameter integer nam=def ;
`define IPIex(nam,def,uni,exc,    des) (*units=uni, type="instance",  desc=des*) parameter integer nam=def exclude exc ;
`define IPIcc(nam,def,uni,lwr,upr,des) (*units=uni, type="instance",  desc=des*) parameter integer nam=def from[lwr:upr] ;
`define IPIoo(nam,def,uni,lwr,upr,des) (*units=uni, type="instance",  desc=des*) parameter integer nam=def from(lwr:upr) ;
`define IPIco(nam,def,uni,lwr,upr,des) (*units=uni, type="instance",  desc=des*) parameter integer nam=def from[lwr:upr) ;
`define IPIoc(nam,def,uni,lwr,upr,des) (*units=uni, type="instance",  desc=des*) parameter integer nam=def from(lwr:upr] ;
`define IPIcz(nam,def,uni,        des) (*units=uni, type="instance",  desc=des*) parameter integer nam=def from[  0:inf);
`define IPIoz(nam,def,uni,        des) (*units=uni, type="instance",  desc=des*) parameter integer nam=def from(  0:inf);

/*
Not all Verilog-A compilers are able to properly collapse internal nodes. To ensure minimal node
count, comment out the following lines:
*/

////////// Function for IDS Calculation //////////
`define VGSeff(V_tra,Vgs,   Vgsefft) \
Vgsefft=Vgs+V_tra+Vdsx*exp(K);\

`define IDS(lambda,V_tra,voff,A,B,C,D,E,F,G,H,a0,a11,b0,b1,b2,beta2,l,ls,ld,Vdsx,w,vsat,nf,Vgs,Tdev,   Ids) \
Vgseff=Vgs+V_tra+Vdsx*exp(K);\
Isat   = nf*w*`P_Q*vsat*(A*tanh(B*pow(Vgseff-voff,5)+C*pow(Vgseff-voff,4)+D*pow(Vgseff-voff,3)+E*pow(Vgseff-voff,2)+F*(Vgseff-voff)+G)+H); \
Ec_T=(a0+a11*(Vgseff-voff))*(b0+b1*(Tdev-`P_CELSIUS0)+b2*pow(Tdev-`P_CELSIUS0,beta2));\
Ids      = Isat*Vdsx*(1+lambda*Vdsx)/pow((pow(Ec_T,beta2)*pow(ls+ld,beta2)+pow(Ec_T*l+Vdsx,beta2)),1/beta2);

module qpzdhemt(d,g,s,dt);
    inout d,g,s,dt;
    electrical d,g,s,y,c,di,gi,si;
    electrical trap1, trap2;
    electrical ia,ib;  // internal nodes to generate noise
    thermal dt;

////////// Clamped Exponential Function //////////
    analog function real lexp;
        input x;
        real x;
        begin
            if(x > `EXPL_THRESHOLD) begin
                lexp = `MAX_EXPL * (1.0+(x)-`EXPL_THRESHOLD);
            end else if(x < -`EXPL_THRESHOLD) begin
                lexp = `MIN_EXPL;
            end else begin
                lexp = exp(x);
            end
        end
    endfunction

////////// Hyperbolic Smoothing Functions (max) //////////
    analog function real hypmax;
        input x , xmin, c;
        real x , xmin, c;
        begin
            hypmax  = xmin + x - 0.5 * (xmin + x - sqrt((x-xmin)*(x-xmin)+c));
        end
    endfunction

////////// Smoothing Function To Fix A Minimum Value //////////
    analog function real smoothminx;
        input x, x0, dx;
        real x, x0, dx;
        begin
            smoothminx = 0.5*(x + x0 + sqrt((x - x0)*(x - x0) + 0.25*dx*dx));
        end
    endfunction

////////// Branches Self-heating //////////
    branch (dt) rth;
    branch (dt) ith;

////////// List Of Model Parameters //////////
    `MPRco( tnom           ,25.0           ,"K"           ,-`P_CELSIUS0,inf         ," Nominal Temperature in degree Celsius" )
    `IPIco( T             ,25              ,""            ,1.0         ,inf         ," Ambient Temperature" )
    `IPRco( l              ,0.25e-6        ,"m"           ,20e-9       ,inf         ," Channel Length" )
    `IPRco( w              ,125.0e-6       ,"m"           ,20e-9       ,inf         ," Channel Width" )
    `IPIco( nf             ,8              ,""            ,1.0         ,inf         ," Number of fingers" )
    `MPRoo( epsilon        ,10.66e-11      ,"F/m"         ,0.0         ,inf         ," Dielectric Permittivity of AlGaN layer" )
    `MPRoo( dd        ,20e-9      ,"m"         ,0.0         ,inf         ," Dielectric thickness of AlGaN layer" )
    `MPRco( u0             ,189.0e-3       ,"m^2/(V * s)" ,0.0         ,inf         ," Low field mobility" )
    `MPRco( ua             ,-1.206         ,"V^-1"        ,-5         ,inf         ," Mobility Degradation coefficient first order" )
    `MPRco( ub             ,0.4407        ,"V^-2"        ,0.0         ,inf         ," Mobility Degradation coefficient second order" )
    `MPRcc( voff           ,-3.007           ,"V"           ,-100.0      ,5           ," Cut-off voltage" )
    `MPRco( vsat           ,1.2e5          ,"cm/s"         ,1.0e3       ,inf         ," Saturation Velocity" )
    `MPRco( thetasat       ,1.64          ,""         ,0        ,inf         ," coff of Mobility and Vds" )
    `MPRcc( sigma           ,1.097e17           ,""           ,1e15      ,1e19           ," sigma" )
    `MPRco( lambda         ,0.0            ,"V^-1"        ,0.0         ,inf         ," Channel Length Modulation Coefficient" )
    `MPRco( Rd              ,2.0         ,"ohm"          ,0            ,inf         ," drain contact resistance" )
    `MPRco( Rg              ,2.1         ,"ohm"          ,0            ,inf         ," gate metallization resistance" )
    `MPRco( Rs              ,0.1         ,"ohm"          ,0            ,inf         ," source contact resistance" )
    `MPRoo( Rgd            ,7.12              ,"ohm"         ,0           ,inf         ," Drain channal resistor " )
    `MPRoo( Ri             ,0.20              ,"ohm"         ,0           ,inf         ," Gate channal resistor " )
////////// QPZD drain current Model Parameters //////////
    `MPRoo( A          ,3.29e16              ,""         ,-inf         ,inf                     ," Iast fitting parameters" )
    `MPRoo( B           ,0.032            ,""         ,-inf         ,inf         ," Iast fitting parameters" )
    `MPRoo( C          ,-0.388         ,""       ,-inf         ,inf         ," Iast fitting parameters" )
    `MPRoo( D          ,1.89              ,""         ,-inf         ,inf                     ," Iast fitting parameters" )
    `MPRoo( E           ,-4.68            ,""         ,-inf         ,inf         ," Iast fitting parameters" )
    `MPRoo( F          ,6.54        ,""       ,-inf         ,inf         ," Iast fitting parameters" )
    `MPRoo( G          ,-4.47         ,""       ,-inf         ,inf         ," Iast fitting parameters" )
    `MPRoo( H          ,3.29e16         ,""       ,-inf         ,inf         ," Iast fitting parameters" )
    `MPRoo( K         ,-100000         ,""       ,-inf         ,inf         ," DIBL fitting parameters" )
    `MPRoo( a0          ,300              ,""         ,-inf         ,inf                     ," Ec_T fitting parameters" )
    `MPRoo( a11           ,-47            ,""         ,-inf         ,inf         ," Ec_T fitting parameters" )
    `MPRoo( b0          ,945         ,""       ,-inf         ,inf         ," Ec_T fitting parameters" )
    `MPRoo( b1          ,-9              ,""         ,-inf         ,inf                     ," Ec_T fitting parameters" )
    `MPRoo( b2           ,0.28            ,""         ,-inf         ,inf         ," Ec_T fitting parameters" )
    `MPRoo( ls          ,2.5e-6        ,""       ,0         ,inf         ," Gate-source distance parameters" )
    `MPRoo( ld          ,3.5e-6        ,""       ,0         ,inf         ," Gate-drain distance parameters" )
    `MPRoo( beta2          ,2        ,""       ,0         ,inf         ," constant parameters" )
////////// Self Heating Model Parameters //////////
    `MPIsw( shmod          ,1              ,""            ," Switch to turn on and off self-heating model" )
    `MPRco( rth0           ,36            ,"K/w"         ,0.0         ,inf         ," Thermal Resistance" )
    `MPRco( cth0           ,10.4e-6         ,"s*w/K"       ,0.0         ,inf         ," Thermal Capacitance" )
////////// Gate current Model Parameters //////////
    `MPIcc( gatemod        ,0              ,""            ,0           ,2           ," Model Switch to turn on and off the gate current" )
    `MPRoo( Is_gs           ,0.001            ,""            ,0.0         ,1.0        ," Gate-source junction diode current " )
    `MPRoo( Is_gd           ,0.001            ,""            ,0.0         ,1.0        ," Gate-drain junction diode current " )
    `MPRoo( n_gs           ,0.14            ,""            ,0.0         ,50.0        ," Gate-source junction diode current ideality factor" )
    `MPRoo( n_gd           ,0.14            ,""            ,0.0         ,50.0        ," Gate-drain junction diode current ideality factor" )
    `MPRoo( njgs           ,2.5            ,""            ,0.0         ,50.0        ," Gate-source junction diode current ideality factor" )
    `MPRoo( njgd           ,2.5            ,""            ,0.0         ,50.0        ," Gate-drain junction diode current ideality factor" )
    `MPRco( igsdio         ,1.0            ,"A/m^2"       ,0.0         ,inf         ," Gate-source junction diode saturation current" )
    `MPRco( igddio         ,1.0            ,"A/m^2"       ,0.0         ,inf         ," Gate-drain junction diode saturation current" )
    `MPRoo( ktgs           ,0.0            ,""            ,-inf        ,inf         ," Temperature co-efficient of gate-source junction diode current" )
    `MPRoo( ktgd           ,0.0            ,""            ,-inf        ,inf         ," Temperature coefficient of gate-drain junction diode current" )
////////// Trap Model  //////////
    `MPIcc( trapmod        ,0              ,""            ,0           ,1           ," Model Switch to turn on and off the dynamic trapping effects" )
    `MPRoo( V0          ,7.8        ,""       ,0         ,inf         ," fitting  parameters" )
    `MPRoo( A_trap          ,-0.005        ,""       ,-1         ,1         ," fitting  parameters" )
    `MPRoo( B_trap          ,0.0005        ,""       ,-1         ,1         ," fitting  parameters" )
    `MPRoo( C_trap          ,0.1174        ,""       ,-1         ,1         ," fitting  parameters" )
////////// Capacitance Parameters //////////
    `MPIcc( Capmod        ,1              ,""            ,0           ,1           ," Model Cap" )
    `MPRco( cgspi           ,0.822e-12        ,"F"           ,-inf         ,inf         ," Gate-source pinch-off capacitance" )
    `MPRco( cgs0           ,0.2748e-12        ,"F"           ,-inf         ,inf         ," Gate-source capacitance parameter" )
    `MPRco( cgdpi           ,0.0510e-12        ,"F"           ,-inf         ,inf         ," Gate-drain pinch-off capacitance" )
    `MPRco( cgd0           ,0.533e-12        ,"F"           ,-inf         ,inf         ," External G-D Capacitor" )
    `MPRoo( P10        ,0.887          ,""           ,-inf         ,inf         ," Polynomial coeff P10 for capacitance" )
    `MPRoo( P11        ,0.177          ,""           ,-inf         ,inf         ," Polynomial coeff P11 for capacitance" )
    `MPRoo( P20        ,1.3295          ,""           ,-inf         ,inf         ," Polynomial coeff P20 for capacitance" )
    `MPRoo( P21        ,-0.8753          ,""           ,-inf         ,inf         ," Polynomial coeff P21 for capacitance" )
    `MPRoo( P22        ,-0.0628          ,""           ,-inf         ,inf         ," Polynomial coeff P22 for capacitance" )
    `MPRoo( P23        ,0.1833          ,""           ,-inf         ,inf         ," Polynomial coeff P23 for capacitance" )
    `MPRoo( P30        ,-0.285          ,""           ,-inf         ,inf         ," Polynomial coeff P30 for capacitance" )
    `MPRoo( P31        ,0.033          ,""           ,-inf         ,inf         ," Polynomial coeff P31 for capacitance" )
    `MPRoo( P40        ,0.155          ,""           ,-inf         ,inf         ," Polynomial coeff P40 for capacitance" )
    `MPRoo( P41        ,0.101          ,""           ,-inf         ,inf         ," Polynomial coeff P41 for capacitance" )
    `MPRoo( P111        ,0.13          ,""           ,-inf         ,inf         ," Polynomial coeff P111 for capacitance" )
    `MPRco( cds           ,270e-15        ,"F"           ,-inf         ,inf         ," Zero-bias D-S junction capacitance" )
////////// Noise Parameters //////////
    `MPIcc( NoiseMod        ,0          ,""              ,0            ,2         ," Globally disable noise" )
    `MPRco( NoiseR          ,0          ,""              ,0            ,inf         ," noise R coeff" )
    `MPRco( NoiseP          ,0          ,""              ,0            ,inf         ," noise P coeff" )
    `MPRcc( NoiseCr         ,0          ,""              ,-1            ,1         ," Gate-drain noise coeff(re)" )
    `MPRcc( NoiseCi         ,0          ,""              ,-1            ,1         ," Gate-drain noise coeff(im)" )
////////// gdsmin For Convergence //////////
    `MPRoo( gdsmin         ,1.0e-12        ,"S"           ,0           ,inf         ," Convergence Parameter" )
////////// unit size //////////
    `MPRco( Ugw             ,125e-6         ,""             ,0            ,inf         ," unit gate width of device" )
    `MPIco( Ngf             ,8           ,""             ,0            ,inf         ," number of device gate fingers" )

////////// Operating Point Variables //////////
    (* desc="ids" *) real ids;
    (* desc="vds" *) real vds;
    (* desc="vgs" *) real vgs;
    (* desc="gm"   *) real gm;
    (* desc="gds"  *) real gds;
    (* desc="igs"   *) real igs;
    (* desc="igd"   *) real igd;
    (* desc="u0_t"   *) real u0_t;
    (* desc="t_total_c"   *) real t_total_c;
    (* desc="t_delta_sh"  *) real t_delta_sh;
    (* desc="cgs" *) real cgs;
    (* desc="cgd" *) real cgd;
///////////////////////////////////////////////////////////////////

    analog begin
        begin : voltages
            real Tnom, Vth;
            real Ids, Vds, Vdsx, Vgs, sigvds,Vgo, Vds_noswap, Vgs_noswap, Vgd_noswap,Vgd,Vgsefft;
            real psi_1, psi_2, psi_3, psi_4;
            real tanh1, tanh2, tanh3, tanh4;
            real Tdev;
            real vth_nT, cn, Nc_nT, w0, vi, Vt_s, V_tra;
            real Isat,Ec_T,Vgseff ;
            real Q_gs,Q_gd;
            real Igs, Igd,t0,t3;
            real Cg;
            real sfx, sfy, Ri_sc, Rgd_sc, Rg_sc, Rd_sc, Rs_sc, cds_sc;

////////// Variable initialization //////////
            Igs = 0.0; Igd = 0.0;

            if ($port_connected(dt) == 0) begin
                if (shmod == 0 || rth0 == 0.0) begin
                    Temp(dt) <+ 0.0;
                end else begin
                    $strobe("5 terminal Module, while 't' node is not connected, SH is activated.");
                end
            end

////////// Temperature Conversion From Celsius To Kelvin //////////
            Tnom = tnom + `P_CELSIUS0;

////////// Terminal Voltage Conditioning //////////
            Vds_noswap = V(di,si);
            Vgs_noswap = V(gi,c);
            Vgd_noswap = V(gi,y);
            sigvds = 1.0;
            if (Vds_noswap < 0.0) begin
                sigvds = -1.0;
                Vds = sigvds*Vds_noswap ;
                Vgs = Vgd_noswap ;
                Vgd = Vgs_noswap ;
            end else begin
                Vds = Vds_noswap ;
                Vgs = Vgs_noswap ;
                Vgd = Vgd_noswap ;
            end
            Vdsx = sqrt(Vds*Vds + 0.01) - 0.1;
            Tdev = T+`P_CELSIUS0 + Temp(rth);
            Vth  = `KboQ * Tdev ;
            Vgo = Vgs- voff ;
            Cg = epsilon/dd ;
            sfx=w/Ugw;
            sfy=nf*1.0/Ngf;
            Ri_sc=Ri/(sfx*sfy);
            Rgd_sc=Rgd/(sfx*sfy);
            Rg_sc=Rg*sfx/sfy;
            Rd_sc=Rd*sfx/sfy;
            Rs_sc=Rs/sfx/sfy;
            cds_sc=cds*sfx*sfy;

////////// Trap Models //////////
            case (trapmod)
                0:begin
                    V(trap1) <+ 0.0;  V(trap2) <+ 0.0;
                    V_tra = 0;
                end
                1:begin
                    vth_nT = pow(3*`k/(0.25*`mn),0.5);
                    cn = `deltan*vth_nT;
                    Nc_nT = 2*pow(((2*3.1415926*0.25*`mn*`k)/(`h*`h)),1.5);
                    w0 = cn*Nc_nT*Tdev*Tdev*exp(-`Eact/((`k/`P_Q)*Tdev));
                    vi = A_trap*Vgs+B_trap*Vds+C_trap;
                    Vt_s = V0/(1+exp(vi/((`k/`P_Q)*Tdev)));
                    I(trap1) <+ w0*`Ct*V(trap1)*exp(vi/((`k/`P_Q)*Tdev));
                    I(trap1) <+ -w0*`Ct*(V0-V(trap1));
                    I(trap1) <+ `Ct*ddt(V(trap1));
                    V_tra = V(trap1)-Vt_s;
                    V(trap2) <+ 0.0;
                end
            endcase
////////// End of Trap Models //////////

////////// Drain current//////////
            `IDS(lambda,V_tra,voff,A,B,C,D,E,F,G,H,a0,a11,b0,b1,b2,beta2,l,ls,ld,Vdsx,w,vsat,nf,Vgs,Tdev,   Ids)
            I(di,si) <+ sigvds*Ids + gdsmin*V(di,si);

////////// Parasitic Resistors //////////
            I(g, gi) <+ 1/Rg_sc*V(g, gi);
            I(d, di) <+ 1/Rd_sc*V(d, di);
            I(s, si) <+ 1/Rs_sc*V(s, si);

////////// Charge model//////////
            `VGSeff(V_tra,Vgs,   Vgsefft)
            psi_1 = P10 + P11 * Vgsefft + P111 * Vds;
            tanh1 = 1 + tanh(psi_1);
            psi_2 = P20 + P21 * Vgsefft + P22 * Vgsefft * Vgsefft + P23 * Vgsefft * Vgsefft *Vgsefft;
            tanh2 = 1 + tanh(psi_2);
            psi_3 = P30 - P31 * Vdsx;
            tanh3 = 1 + tanh(psi_3);
            psi_4 = P40 + P41 * Vgsefft - P111 * Vdsx;
            tanh4 = 1 + tanh(psi_4) + 2 * P111;

            case(Capmod)
            0: begin  // Linear capacitance
               Q_gs= cgspi*sfx*sfy ;
               Q_gd= cgdpi*sfx*sfy;
            end
            1: begin  // Bias dependent capacitance
               Q_gs = (cgspi + cgs0 * tanh1 * tanh2)*sfx*sfy;
               Q_gd = (cgdpi + cgd0 * (tanh3 * tanh4))*sfx*sfy;
            end
            endcase

////////// Gate Current Model //////////
            case(gatemod)
            0: begin  // Linear capacitance
                I(gi, si) <+ 0;
                I(gi, di) <+ 0;
            end
            1: begin
                Igs =Is_gs*lexp(Vgs/n_gs)*sfx*sfy;
                Igd =Is_gd*lexp(Vgd/n_gd)*sfx*sfy;
                I(gi, si) <+ Igs;
                I(gi, di) <+ Igd;
            end
            2: begin
                t0 = V(gi, si)/(njgs*`KboQ*Tdev);
                t3 = igsdio + (Tdev/Tnom - 1.0)* ktgs;
                Igs = w*l*nf*abs(t3)*(lexp(t0)-1.0);
                t0 = V(gi, di)/(njgd*`KboQ*Tdev);
                t3 = igddio + (Tdev/Tnom - 1.0)* ktgd;
                Igd = w*l*nf*abs(t3)*(lexp(t0)-1.0);
                I(gi, si) <+ Igs;
                I(gi, di) <+ Igd;
            end
            endcase
////////// Noise Model //////////
            case(NoiseMod)
            0: begin
                I(gi, si) <+ 0;
                I(gi, di) <+ 0;
            end
            1: begin
            begin: QPZDnoise
           	 real NoisePwrD, NoisePwrG;
            	 real cbar, ki, NoiseC;
	 real Temp, Tnomk;
            	 real u0_T,ueff,u_n,Imax_vsi,Ec_vsi,vsi,vL,Aig,Aid,Big,Cig;

             	 Temp = T + `P_CELSIUS0;
            	 Tnomk = tnom + `P_CELSIUS0;
            	 u0_T=u0*((Temp)/Tnomk)**(-0.5864);
            	 Imax_vsi=(nf*w)*`P_Q*sigma*vsat;
            	 ueff=u0_T/(1+ua*Vgo+ub*Vgo**2);
            	 u_n=ueff/sqrt(1+thetasat**2*Vdsx**2);
            	 Ec_vsi=2**(1/beta2)*vsat/u_n;
            	 vsi=(Ec_vsi*ls*Ids)/(Imax_vsi**beta2-Ids**beta2)**(1/beta2);
            	 vL=Vgo-sqrt(max((Vgo-vsi)**2-(2*Ids*l)/((nf*w)*u_n*Cg),0));
            	 Aig=0.5*Vgo*(vL-vsi)**2-(`Oneby6)*(vL*(vL**2-vsi**2)-2*vsi**2*(vL-vsi));
            	 Aid=(vL-vsi)*Vgo**2-(vL**2-vsi**2)*Vgo+(`Oneby3)*(vL**3-vsi**3);
            	 Big=0.5*Vgo**2*(vL-vsi)**2-(`Oneby3)*Vgo*(vL*(vL**2-vsi**2)-2*vsi**2*(vL-vsi))+(`Oneby12)*(vL*(vL**3-vsi**3)-3*vsi**3*(vL-vsi));
            	 Cig=(`Oneby3)*Vgo**2*(vL**3-3*vL**2*vsi+3*vL*vsi**2-vsi**3)+(`Oneby6)*Vgo*(6*vL**2*vsi**2-8*vL*vsi**3+3*vsi**4-vL**4)+(`Oneby30)*(vL**5-10*vL**2*vsi**3+15*vL*vsi**4-6*vsi**5);

                NoisePwrD =  ((4* `P_K * Tdev *(nf*w)**2*Cg**2*u_n**2)/(l**2*Ids))*Aid;

                NoisePwrG = (4* `P_K * Tdev *(nf*w)**6*Cg**6*u_n**4)/(Ids**5*l**2)*(Aig**2*Aid-(2*Ids*l)/(Cg*(nf*w)*u_n)*Aig*Big+(Ids**2*l**2*Cig)/(Cg**2*(nf*w)**2*u_n**2));

                begin: correlated_noise
                    NoiseC = -(Aig*Aid-(Ids*l*Big)/((nf*w)*u_n*Cg))/sqrt(Aid*(Aig**2*Aid-(2*Ids*l*Aig*Big)/(Cg*u_n*(nf*w))+(Ids**2*l**2*Cig)/(Cg**2*u_n**2*(nf*w)**2)));
                    ki = NoiseC *sqrt(NoisePwrD*NoisePwrG)/NoisePwrD;
                    cbar = sqrt(1.0-NoiseC**2);
                    I(ia) <+ V(ia);
                    I(ia) <+ white_noise(NoisePwrG, "gate");
                    I(ib) <+ V(ib) + white_noise(NoisePwrD, "drain");
                    I(di,si)<+ V(ib);
                    I(gi,si)<+ cbar * ddt(V(ia)) + ki * ddt(V(ib));
                u0_t  = NoisePwrG;
                end
                I(g, gi) <+ white_noise(4*`P_K * Temp/Rg_sc, "resistor");
                I(d, di) <+ white_noise(4*`P_K * Temp/Rd_sc, "resistor");
                I(s, si) <+ white_noise(4*`P_K * Temp/Rs_sc, "resistor");
            end
            end

            2: begin
            begin: PRCnoise
           	 real NoisePwrD, NoisePwrG, gm, Cgs0;
            	 real cr, ci, cbar, kr, ki, NoiseC;
	 real Tnomk;
            	 Tnomk = tnom + `P_CELSIUS0;

                gm = ddx(Ids, V(gi));

                Cgs0 = Q_gs;

                NoisePwrD =  4.0 * `P_K * Tdev * gm * NoiseP;

                if (gm > 0)
                    NoisePwrG = Cgs0 * Cgs0 * 4.0 * `P_K * Tdev * NoiseR / gm;
                else
                    NoisePwrG = 0.0;

                begin: correlated_noise
                    NoiseC = sqrt(NoiseCr**2+NoiseCi**2);
                    ki = NoiseCi * Cgs0 * sqrt(NoiseR / NoiseP)/gm;
                    kr = NoiseCr * Cgs0 * sqrt(NoiseR / NoiseP)/gm;
                    cbar = sqrt(1.0-NoiseC**2);
                    I(ia) <+ V(ia);
                    I(ia) <+ white_noise(NoisePwrG, "gate");
                    I(ib) <+ V(ib) + white_noise(NoisePwrD, "drain");
                    I(di,si)<+ V(ib);
                    I(gi,si)<+ cbar * ddt(V(ia)) + ki * ddt(V(ib)) - kr * 2*`M_PI * $realfreq * V(ib);
                    I(g, gi) <+ white_noise(4*`P_K * Tdev/Rg_sc, "resistor");
                    I(d, di) <+ white_noise(4*`P_K * Tdev/Rd_sc, "resistor");
                    I(s, si) <+ white_noise(4*`P_K * Tdev/Rs_sc, "resistor");
                end
            end
            end
            endcase
////////// Resistor Contributions //////////
            I(y,di) <+ 1/Rgd_sc*V(y,di);
            I(c,si) <+ 1/Ri_sc*V(c,si);

////////// Capacitance Contributions //////////
            I(di,si) <+ ddt(cds_sc*Vds);
            I(gi,y) <+ Q_gd * ddt(V(gi,y));
            I(gi,c) <+ Q_gs * ddt(V(gi,c));

////////// Self-Heating Effect //////////
            if (shmod == 1 && rth0>0) begin
                Pwr(ith) <+ -1.0*Ids*Vds;
                Pwr(rth) <+ Temp(rth)/rth0;
                Pwr(rth) <+ ddt(Temp(rth)*cth0);
            end else begin
                Temp(dt) <+ 0.0 ;
            end

/////////  Output info variables
            ids = Ids;
            vds = V(di,si);
            vgs = Vgs;
            gm   = sigvds * ddx(Ids,V(g));
            gds  = sigvds * ddx(Ids,V(d));
            igs   = Igs;
            igd   = Igd;

            t_total_c  = Tdev - `P_CELSIUS0;
            t_delta_sh = Temp(dt);
            cgs        = Q_gs;
            cgd        = Q_gd;
       end
   end
endmodule
